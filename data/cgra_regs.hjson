// Copyright EPFL contributors.
// Licensed under the Apache License, Version 2.0, see LICENSE for details.
// SPDX-License-Identifier: Apache-2.0

{ name: "cgra",
  clock_primary: "clk_i",
  bus_interfaces: [
    { protocol: "reg_iface", direction: "device" }
  ],
  regwidth: "32",
  registers: [
    { name:     "COL_STATUS",
      desc:     "CGRA columns status (0:free, 1:used)",
      swaccess: "ro",
      hwaccess: "hrw",
      resval:   0, // all column free
      fields: [
        { bits: "3:0", name: "COL_STATUS", desc: "CGRA columns status (0:free, 1:used)" }
      ]
    },
    { name:     "SLOT0_KER_ID",
      desc:     "Slot 0 kernel ID",
      swaccess: "rw",
      hwaccess: "hrw",
      fields: [
        { bits: "31:0", name: "SLOT0_KER_ID", desc: "Slot 0 kernel ID" }
      ]
    },
    { name:     "SLOT1_KER_ID",
      desc:     "Slot 1 kernel ID",
      swaccess: "rw",
      hwaccess: "hrw",
      fields: [
        { bits: "31:0", name: "SLOT1_KER_ID", desc: "Slot 1 kernel ID" }
      ]
    },
    { name:     "SLOT0_PTR_IN_C0",
      desc:     "Slot 0 input data pointer for first column used",
      swaccess: "rw",
      hwaccess: "hro",
      fields: [
        { bits: "31:0", name: "SLOT0_PTR_IN_C0", desc: "Slot 0 input data pointer for first column used" }
      ]
    },
    { name:     "SLOT0_PTR_OUT_C0",
      desc:     "Slot 0 output data pointer for first column used",
      swaccess: "rw",
      hwaccess: "hro",
      fields: [
        { bits: "31:0", name: "SLOT0_PTR_OUT_C0", desc: "Slot 0 output data pointer for first column used" }
      ]
    },
    { name:     "SLOT0_PTR_IN_C1",
      desc:     "Slot 0 input data pointer for second column used",
      swaccess: "rw",
      hwaccess: "hro",
      fields: [
        { bits: "31:0", name: "SLOT0_PTR_IN_C1", desc: "Slot 0 input data pointer for second column used" }
      ]
    },
    { name:     "SLOT0_PTR_OUT_C1",
      desc:     "Slot 0 Output data pointer for second column used",
      swaccess: "rw",
      hwaccess: "hro",
      fields: [
        { bits: "31:0", name: "SLOT0_PTR_OUT_C1", desc: "Slot 0 Output data pointer for second column used" }
      ]
    },
    { name:     "SLOT0_PTR_IN_C2",
      desc:     "Slot 0 input data pointer for third column used",
      swaccess: "rw",
      hwaccess: "hro",
      fields: [
        { bits: "31:0", name: "SLOT0_PTR_IN_C2", desc: "Slot 0 input data pointer for third column used" }
      ]
    },
    { name:     "SLOT0_PTR_OUT_C2",
      desc:     "Slot 0 output data pointer for first column used",
      swaccess: "rw",
      hwaccess: "hro",
      fields: [
        { bits: "31:0", name: "SLOT0_PTR_OUT_C2", desc: "Slot 0 output data pointer for first column used" }
      ]
    },
    { name:     "SLOT0_PTR_IN_C3",
      desc:     "Slot 0 input data pointer for fourth column used",
      swaccess: "rw",
      hwaccess: "hro",
      fields: [
        { bits: "31:0", name: "SLOT0_PTR_IN_C3", desc: "Slot 0 input data pointer for fourth column used" }
      ]
    },
    { name:     "SLOT0_PTR_OUT_C3",
      desc:     "Slot 1 output data pointer for fourth column used",
      swaccess: "rw",
      hwaccess: "hro",
      fields: [
        { bits: "31:0", name: "SLOT0_PTR_OUT_C3", desc: "Slot 0 output data pointer for fourth column used" }
      ]
    },

    { name:     "SLOT1_PTR_IN_C0",
      desc:     "Slot 1 input data pointer for first column used",
      swaccess: "rw",
      hwaccess: "hro",
      fields: [
        { bits: "31:0", name: "SLOT1_PTR_IN_C0", desc: "Slot 1 input data pointer for first column used" }
      ]
    },
    { name:     "SLOT1_PTR_OUT_C0",
      desc:     "Slot 1 output data pointer for first column used",
      swaccess: "rw",
      hwaccess: "hro",
      fields: [
        { bits: "31:0", name: "SLOT1_PTR_OUT_C0", desc: "Slot 1 output data pointer for first column used" }
      ]
    },
    { name:     "SLOT1_PTR_IN_C1",
      desc:     "Slot 1 input data pointer for second column used",
      swaccess: "rw",
      hwaccess: "hro",
      fields: [
        { bits: "31:0", name: "SLOT1_PTR_IN_C1", desc: "Slot 1 input data pointer for second column used" }
      ]
    },
    { name:     "SLOT1_PTR_OUT_C1",
      desc:     "Slot 1 Output data pointer for second column used",
      swaccess: "rw",
      hwaccess: "hro",
      fields: [
        { bits: "31:0", name: "SLOT1_PTR_OUT_C1", desc: "Slot 1 Output data pointer for second column used" }
      ]
    },
    { name:     "SLOT1_PTR_IN_C2",
      desc:     "Slot 1 input data pointer for third column used",
      swaccess: "rw",
      hwaccess: "hro",
      fields: [
        { bits: "31:0", name: "SLOT1_PTR_IN_C2", desc: "Slot 1 input data pointer for third column used" }
      ]
    },
    { name:     "SLOT1_PTR_OUT_C2",
      desc:     "Slot 1 output data pointer for first column used",
      swaccess: "rw",
      hwaccess: "hro",
      fields: [
        { bits: "31:0", name: "SLOT1_PTR_OUT_C2", desc: "Slot 1 output data pointer for first column used" }
      ]
    },
    { name:     "SLOT1_PTR_IN_C3",
      desc:     "Slot 1 input data pointer for fourth column used",
      swaccess: "rw",
      hwaccess: "hro",
      fields: [
        { bits: "31:0", name: "SLOT1_PTR_IN_C3", desc: "Slot 1 input data pointer for fourth column used" }
      ]
    },
    { name:     "SLOT1_PTR_OUT_C3",
      desc:     "Slot 1 output data pointer for fourth column used",
      swaccess: "rw",
      hwaccess: "hro",
      fields: [
        { bits: "31:0", name: "SLOT1_PTR_OUT_C3", desc: "Slot 1 output data pointer for fourth column used" }
      ]
    },
    { name:     "PERF_CNT_ENABLE",
      desc:     "Enable performance counters",
      swaccess: "rw",
      hwaccess: "hro",
      fields: [
        { bits: "0", name: "PERF_CNT_ENABLE", desc: "Enable performance counters" }
      ]
    },
    { name:     "PERF_CNT_RESET",
      desc:     "Reset performance counters",
      swaccess: "rw",
      hwaccess: "hrw",
      fields: [
        { bits: "0", name: "PERF_CNT_RESET", desc: "Reset performance counters" }
      ]
    },
    { name:     "PERF_CNT_TOTAL_KERNELS",
      desc:     "Total number of kernels executed (all columns)",
      swaccess: "rw",
      hwaccess: "hrw",
      fields: [
        { bits: "31:0", name: "PERF_CNT_TOTAL_KERNELS", desc: "Total number of kernels executed" }
      ]
    },
    { name:     "PERF_CNT_C0_ACTIVE_CYCLES",
      desc:     "Number of active cycles (configuration+execution)) of column 0",
      swaccess: "rw",
      hwaccess: "hrw",
      fields: [
        { bits: "31:0", name: "PERF_CNT_C0_ACTIVE_CYCLES", desc: "Number of active cycles (configuration+execution)) of column 0" }
      ]
    },
    { name:     "PERF_CNT_C0_STALL_CYCLES",
      desc:     "Number of stall cycles during execution of column 0",
      swaccess: "rw",
      hwaccess: "hrw",
      fields: [
        { bits: "31:0", name: "PERF_CNT_C0_STALL_CYCLES", desc: "Number of stall cycles during execution of column 0" }
      ]
    },
    { name:     "PERF_CNT_C1_ACTIVE_CYCLES",
      desc:     "Number of active cycles (configuration+execution)) of column 1",
      swaccess: "rw",
      hwaccess: "hrw",
      fields: [
        { bits: "31:0", name: "PERF_CNT_C1_ACTIVE_CYCLES", desc: "Number of active cycles (configuration+execution)) of column 1" }
      ]
    },
    { name:     "PERF_CNT_C1_STALL_CYCLES",
      desc:     "Number of stall cycles during execution of column 1",
      swaccess: "rw",
      hwaccess: "hrw",
      fields: [
        { bits: "31:0", name: "PERF_CNT_C1_STALL_CYCLES", desc: "Number of stall cycles during execution of column 1" }
      ]
    },
    { name:     "PERF_CNT_C2_ACTIVE_CYCLES",
      desc:     "Number of active cycles (configuration+execution) )of column 2",
      swaccess: "rw",
      hwaccess: "hrw",
      fields: [
        { bits: "31:0", name: "PERF_CNT_C2_ACTIVE_CYCLES", desc: "Number of active cycles (configuration+execution) )of column 2" }
      ]
    },
    { name:     "PERF_CNT_C2_STALL_CYCLES",
      desc:     "Number of stall cycles during execution of column 2",
      swaccess: "rw",
      hwaccess: "hrw",
      fields: [
        { bits: "31:0", name: "PERF_CNT_C2_STALL_CYCLES", desc: "Number of stall cycles during execution of column 2" }
      ]
    },
    { name:     "PERF_CNT_C3_ACTIVE_CYCLES",
      desc:     "Number of active cycles (configuration+execution) of column 3",
      swaccess: "rw",
      hwaccess: "hrw",
      fields: [
        { bits: "31:0", name: "PERF_CNT_C3_ACTIVE_CYCLES", desc: "Number of active cycles (configuration+execution) of column 3" }
      ]
    },
    { name:     "PERF_CNT_C3_STALL_CYCLES",
      desc:     "Number of stall cycles during execution of column 3",
      swaccess: "rw",
      hwaccess: "hrw",
      fields: [
        { bits: "31:0", name: "PERF_CNT_C3_STALL_CYCLES", desc: "Number of stall cycles during execution of column 3" }
      ]
    },
    { name:     "RESERVED30",
      desc:     "Reserved",
      swaccess: "ro",
      hwaccess: "hro",
      fields: [
        { bits: "31:0", name: "RESERVED30", desc: "Reserved" }
      ]
    },
    { name:     "RESERVED31",
      desc:     "Reserved",
      swaccess: "ro",
      hwaccess: "hro",
      fields: [
        { bits: "31:0", name: "RESERVED31", desc: "Reserved" }
      ]
    },
   ]
}
